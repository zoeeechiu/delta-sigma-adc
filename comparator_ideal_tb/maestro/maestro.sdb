ADE simulation setup
Run mode: Single Run, Sweeps and Corners
Tests:
  adc_comparator_ideal_tb_1: adc/comparator_ideal_tb/schematic, simulator spectre
