ADE simulation setup
Test adc_comparator_ideal_tb_1: adc/comparator_ideal_tb/schematic, simulator spectre
  Models: /opt/cadence-designkits/gpdk045_v_6_0/gpdk045/../models/spectre/gpdk045.scs[mc]
  Temperature: 27
  Analysis tran: stop=2u
  Signals: /comp_out, /net1, /net2, /net3
Run mode: Single Run, Sweeps and Corners
