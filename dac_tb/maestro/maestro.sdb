ADE simulation setup
Run mode: Single Run, Sweeps and Corners
Tests:
  adc_dac_tb_1: adc/dac_tb/schematic, simulator spectre
