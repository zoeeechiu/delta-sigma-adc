ADE simulation setup
Test adc_dac_tb_1: adc/dac_tb/schematic, simulator spectre
  Models: /opt/cadence-designkits/gpdk045_v_6_0/gpdk045/../models/spectre/gpdk045.scs[mc]
  Temperature: 27
  Analysis tran: stop=1u
  Analysis dc: (saves the operating point)
Run mode: Single Run, Sweeps and Corners
