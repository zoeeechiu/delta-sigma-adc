ADE simulation setup
Test ECE4530_2026_MP2_test_bench_1: adc/integrator_testbench/schematic, simulator spectre
  Models: /opt/cadence-designkits/gpdk045_v_6_0/gpdk045/../models/spectre/gpdk045.scs[mc]
  Variables: AC_CM = 0; AC_DM = 1; Vbias = 1.4; vdd = 2.4
  Temperature: 27
  Analysis tran: stop=2.2u errpreset=moderate maxstep=1n
  Output diff output = (VT("/out_p") - VT("/out_n"))
  Output phi1 = VT("/phi1")
  Output phi2 = VT("/phi2")
  Output common mode = ((VT("/out_p") + VT("/out_n")) / 2)
  Output rst = VT("/rst")
  Signals: /out_p, /out_n, /rst
Run mode: Single Run, Sweeps and Corners
