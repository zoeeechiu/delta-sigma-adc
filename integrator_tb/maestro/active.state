ADE simulation setup
Test ECE4530_2026_MP2_test_bench_1: adc/integrator_tb/schematic, simulator spectre
  Models: /opt/cadence-designkits/gpdk045_v_6_0/gpdk045/../models/spectre/gpdk045.scs[mc]
  Variables: vcmi = 1.4; AC_CM = 0; AC_DM = 1; Vbias = 1.4; vdd = 2.4
  Temperature: 27
  Analysis tran: stop=10u errpreset=moderate maxstep=1n
  Analysis dc: (saves the operating point)
  Output diff output = (VT("/outp") - VT("/outn"))
  Output phi1 = VT("/phi1") (unticked)
  Output phi2 = VT("/phi2") (unticked)
  Output common mode = ((VT("/outp") + VT("/outn")) / 2)
  Output rst = VT("/rst") (unticked)
  Signals: /rst, /outp, /outn
Run mode: Single Run, Sweeps and Corners
