ADE simulation setup
Run mode: Single Run, Sweeps and Corners
Tests:
  ECE4530_2026_MP2_test_bench_1: adc/modulator_tb/schematic, simulator spectre
    Variables: AC_CM = 0; AC_DM = 1; Vbias = 1.4; vdd = 2.4; vcmi = 1.4
    Outputs: ((OutP + OutN) / 2); (20 * log10(((OutP + OutN) / 2))); (20 * log10(((vfreq('ac "/out_p") + vfreq('ac "/out_n")) / 2))); (db(((OutP + OutN) / 2))); int1 output; phi1; phi2; common mode; rst; bitstream; dac; int2 output
