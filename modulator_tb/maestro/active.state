ADE simulation setup
Test ECE4530_2026_MP2_test_bench_1: adc/modulator_tb/schematic, simulator spectre
  Models: /opt/cadence-designkits/gpdk045_v_6_0/gpdk045/../models/spectre/gpdk045.scs[mc]
  Variables: AC_CM = 0; AC_DM = 1; Vbias = 1.4; vdd = 2.4
  Temperature: 27
  Analysis tran: stop=20u errpreset=moderate maxstep=1n
  Output int1 output = (VT("/outp1") - VT("/outn1"))
  Output phi1 = VT("/phi1")
  Output phi2 = VT("/phi2")
  Output common mode = ((VT("/outp1") + VT("/outn1")) / 2) (unticked)
  Output rst = VT("/rst")
  Output bitstream = VT("/out")
  Output dac = (VT("/vdac+") - VT("/vdac-"))
  Output int2 output = (VT("/outp2") - VT("/outn2"))
  Signals: /rst, /out, /vdac+, /vdac-, /outp1, /outn1, /outp2, /outn2
Run mode: Single Run, Sweeps and Corners
Setup values for test ECE4530_2026_MP2_test_bench_1: vcmi = 1.4
